* Fully Differential OTA with Stable CMFB Layout

.include "tsmc180nm.lib"

*===================================================================
* Supplies & Biasing
*===================================================================
VDD      vdd       0     DC 1.8
Vbias    vbias     0     DC 0.62
Vref     vref      0     DC 0.9

* CHANGE 1: Tracking PMOS Current Mirror Reference (Fixes Deadlock)
Ibias_p  vdd       vbias_p   DC 300u
Mref_p   vbias_p   vbias_p   vdd     vdd   PMOS W=28u L=0.18u

* Differential Input (Small-signal adjusted for realistic transient)
Vinp     inp       0     DC 0.9 AC 0.5  SIN(0.9 5m 1k)
Vinn     inn       0     DC 0.9 AC -0.5 SIN(0.9 -5m 1k)

*===================================================================
* Output Loads
*===================================================================
CLp      voutp     0     1p
CLn      voutn     0     1p

*===================================================================
* FDA OTA Core
*===================================================================
* Input Differential Pair
M1       voutn     inp   vtail     0     NMOS W=10u L=0.18u
M2       voutp     inn   vtail     0     NMOS W=10u L=0.18u

* PMOS High-Impedance Loads
M3       voutn     vbias_p vdd     vdd   PMOS W=28u L=0.18u
M4       voutp     vbias_p vdd     vdd   PMOS W=28u L=0.18u

* CHANGE 2: Expanded Main Tail Current Source Width (Fixes Headroom)
M5       vtail     vcmfb_out 0     0     NMOS W=40u L=0.18u

*===================================================================
* Common Mode Feedback (CMFB) Network
*===================================================================
* Passive Common-Mode Detector
Rcm1     voutp     vcm_sense 1meg
Rcm2     voutn     vcm_sense 1meg

* CMFB Error Amplifier
M6       vcmfb_n   vcm_sense vcm_tail 0  NMOS W=10u L=0.18u
M7       vcmfb_out vref      vcm_tail 0  NMOS W=10u L=0.18u

* Active PMOS Loads for CMFB Error Amp
M8       vcmfb_n   vcmfb_n   vdd     vdd   PMOS W=28u L=0.18u
M9       vcmfb_out vcmfb_n   vdd     vdd   PMOS W=28u L=0.18u

* CMFB Tail Current Source
M10      vcm_tail  vbias     0       0     NMOS W=40u L=0.18u

* CHANGE 3: Dominant-Pole Compensation Capacitor (Kills Oscillation)
Ccmfb    vcmfb_out 0         3p

*===================================================================
* Simulation Settings & Convergence Helpers
*===================================================================
.nodeset v(voutp)=0.9
.nodeset v(voutn)=0.9
.nodeset v(vcm_sense)=0.9

.options reltol=0.01
.options abstol=1e-9
.options vntol=1e-6

*===================================================================
* Analyses
*===================================================================
.op
.ac dec 100 1 10G
.tran 1n 2u

*===================================================================
* Data Output Setup (Includes vcm_tail tracking)
*===================================================================
.save v(voutp) v(voutn) v(vcm_sense) v(vcmfb_out) v(vtail) v(vcm_tail)

.control
run
.endc

.end
